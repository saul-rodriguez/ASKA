ADE simulation setup
Run mode: Single Run, Sweeps and Corners
Tests:
  ALL_TESTS:current_source_nedia4:1: ALL_TESTS/current_source_nedia4/schematic, simulator spectre
    Outputs: deriv(IS("/M0/D"))
  Montecarlo (off): ALL_TESTS/current_source_nedia4/schematic, simulator spectre
    Outputs: deriv(IS("/M0/D"))
Global variables:
  IB1 = 1u
  VIN = 1.0
