ADE simulation setup
Run mode: Single Run, Sweeps and Corners
Tests:
  ALL_TESTS:emir_test_2_tb:1 (off): ALL_TESTS/emir_test_2_tb/config, simulator spectre
  ALL_TESTS:emir_test_2_tb:1:1 (off): ALL_TESTS/emir_test_2_tb/config, simulator spectre
  ALL_TESTS:emir_test_2_tb:2 (off): ALL_TESTS/emir_test_2_tb/config, simulator spectre
  TOP (off): ALL_TESTS/emir_test_2_tb/config, simulator spectre
  TOP_EMIR: ALL_TESTS/emir_test_2_tb/config, simulator spectre
Global variables:
  VDC = 20
