// VerilogA for PULSE_GENERATOR, pulse_generator_stimulus, veriloga

`include "constants.vams"
`include "disciplines.vams"

module pulse_generator_stimulus(UP1,DOWN1,UP2,DOWN2,EN_CS_N,DAC[5:0]);

inout UP1,DOWN1,UP2,DOWN2,EN_CS_N,DAC[5:0];
electrical UP1,DOWN1,UP2,DOWN2,EN_CS_N,DAC[5:0];

parameter real td = 0.0;
//parameter real tt = 100e-12;
parameter real tt = 5e-9;

parameter real start_delay = 100e-6;
parameter real pause_duration = 50e-6;
parameter real phase_duration = 100e-6;

parameter real init_up1 = 0;
parameter real init_up2 = 0;
parameter real init_dn1 = 0;
parameter real init_dn2 = 0;

parameter real vref = 0;
parameter real vref2 = 1.65;

//parameter dahc = 0;

parameter integer value0 = 0; //initial value
parameter integer value1 = 0;
parameter integer value2 = 0;
parameter integer value3 = 0;

real u1,u2,d1,d2;
real time_aux;
real time_aux2;
real vdac;
real dummy;
real dac[5:0];

real en_cs;

analog begin

	@(initial_step) begin
		u1 = init_up1;
		u2 = init_up2;
		d1 = init_dn1;
		d2 = init_dn2;
		time_aux = start_delay+phase_duration+pause_duration+phase_duration;
		time_aux2 = 2*time_aux + phase_duration;
		//vdac = vref;
		//vdac = 0;
	//	dummy = 0;
		dac[0] = 3.3*((value0 & (1 << 0))? 1:0);
		dac[1] = 3.3*((value0 & (1 << 1))? 1:0);
		dac[2] = 3.3*((value0 & (1 << 2))? 1:0);
		dac[3] = 3.3*((value0 & (1 << 3))? 1:0);
		dac[4] = 3.3*((value0 & (1 << 4))? 1:0);
		dac[5] = 3.3*((value0 & (1 << 5))? 1:0);

		//en_cs = 3.3;
		en_cs = 0.0;
	end

	@(timer(start_delay)) begin
		u1 = 3.3;
		u2 = 0;
		d1 = 0;
		d2 = 3.3;
//		vdac = vref;
//		dummy = 0;

		dac[0] = 3.3*((value1 & (1 << 0))? 1:0);
		dac[1] = 3.3*((value1 & (1 << 1))? 1:0);
		dac[2] = 3.3*((value1 & (1 << 2))? 1:0);
		dac[3] = 3.3*((value1 & (1 << 3))? 1:0);
		dac[4] = 3.3*((value1 & (1 << 4))? 1:0);
		dac[5] = 3.3*((value1 & (1 << 5))? 1:0);

//		en_cs = 0;
		en_cs = 3.3;
	end

	@(timer(start_delay+phase_duration)) begin
		u1 = 0;
		u2 = 0;
		d1 = 0;
		d2 = 0;
//		vdac = 0;
//		dummy = 3.3;
		dac[0] = 0;
		dac[1] = 0;
		dac[2] = 0;
		dac[3] = 0;
		dac[4] = 0;
		dac[5] = 0;

		//en_cs = 3.3;
		en_cs = 0.0;

	end

	@(timer(start_delay+phase_duration+pause_duration)) begin
		u1 = 0;
		u2 = 3.3;
		d1 = 3.3;
		d2 = 0;
		//vdac = vref;
		//dummy = 0;
		dac[0] = 3.3*((value1 & (1 << 0))? 1:0);
		dac[1] = 3.3*((value1 & (1 << 1))? 1:0);
		dac[2] = 3.3*((value1 & (1 << 2))? 1:0);
		dac[3] = 3.3*((value1 & (1 << 3))? 1:0);
		dac[4] = 3.3*((value1 & (1 << 4))? 1:0);
		dac[5] = 3.3*((value1 & (1 << 5))? 1:0);

		//en_cs = 0;
		en_cs = 3.3;
	end

	@(timer(start_delay+phase_duration+pause_duration+phase_duration)) begin
		u1 = 0;
		u2 = 0;
		d1 = 0;
		d2 = 0;
//		vdac = 0;
//		dummy = 3.3;
		dac[0] = 0;
		dac[1] = 0;
		dac[2] = 0;
		dac[3] = 0;
		dac[4] = 0;
		dac[5] = 0;

	//	en_cs = 3.3;
		en_cs = 0.0;
	end

	//Start again 1
	@(timer(time_aux + start_delay)) begin
		u1 = 3.3;
		u2 = 0;
		d1 = 0;
		d2 = 3.3;
		//vdac = vref;
		//dummy = 0;
		dac[0] = 3.3*((value2 & (1 << 0))? 1:0);
		dac[1] = 3.3*((value2 & (1 << 1))? 1:0);
		dac[2] = 3.3*((value2 & (1 << 2))? 1:0);
		dac[3] = 3.3*((value2 & (1 << 3))? 1:0);
		dac[4] = 3.3*((value2 & (1 << 4))? 1:0);
		dac[5] = 3.3*((value2 & (1 << 5))? 1:0);

		//en_cs = 0;
		en_cs = 3.3;
	end

	@(timer(time_aux + start_delay+phase_duration)) begin
		u1 = 0;
		u2 = 0;
		d1 = 0;
		d2 = 0;
		//vdac = 0;
		//dummy = 3.3;
		dac[0] = 0;
		dac[1] = 0;
		dac[2] = 0;
		dac[3] = 0;
		dac[4] = 0;
		dac[5] = 0;

		//en_cs = 3.3;
		en_cs = 0.0;

	end

	@(timer(time_aux + start_delay+phase_duration+pause_duration)) begin
		u1 = 0;
		u2 = 3.3;
		d1 = 3.3;
		d2 = 0;
		//vdac = vref;
		//dummy = 0;
		dac[0] = 3.3*((value2 & (1 << 0))? 1:0);
		dac[1] = 3.3*((value2 & (1 << 1))? 1:0);
		dac[2] = 3.3*((value2 & (1 << 2))? 1:0);
		dac[3] = 3.3*((value2 & (1 << 3))? 1:0);
		dac[4] = 3.3*((value2 & (1 << 4))? 1:0);
		dac[5] = 3.3*((value2 & (1 << 5))? 1:0);

		//en_cs = 0;
		en_cs = 3.3;
	end

	@(timer(time_aux + start_delay+phase_duration+pause_duration+phase_duration)) begin
		u1 = 0;
		u2 = 0;
		d1 = 0;
		d2 = 0;
	//	vdac = 0;
	//	dummy = 3.3;
		dac[0] = 0;
		dac[1] = 0;
		dac[2] = 0;
		dac[3] = 0;
		dac[4] = 0;
		dac[5] = 0;

//		en_cs = 3.3;
		en_cs = 0.0;
	end

	//Start again 2
	@(timer(time_aux2 + start_delay)) begin
		u1 = 3.3;
		u2 = 0;
		d1 = 0;
		d2 = 3.3;
	//	vdac = vref2;
	//	dummy = 0;
		dac[0] = 3.3*((value3 & (1 << 0))? 1:0);
		dac[1] = 3.3*((value3 & (1 << 1))? 1:0);
		dac[2] = 3.3*((value3 & (1 << 2))? 1:0);
		dac[3] = 3.3*((value3 & (1 << 3))? 1:0);
		dac[4] = 3.3*((value3 & (1 << 4))? 1:0);
		dac[5] = 3.3*((value3 & (1 << 5))? 1:0);

		//en_cs = 0;
		en_cs = 3.3;
	end

	@(timer(time_aux2 + start_delay+phase_duration)) begin
		u1 = 0;
		u2 = 0;
		d1 = 0;
		d2 = 0;
	//	vdac = 0;
	//	dummy = 3.3;
		dac[0] = 0;
		dac[1] = 0;
		dac[2] = 0;
		dac[3] = 0;
		dac[4] = 0;
		dac[5] = 0;

		//en_cs = 3.3;
		en_cs = 0;
	end

	@(timer(time_aux2 + start_delay+phase_duration+pause_duration)) begin
		u1 = 0;
		u2 = 3.3;
		d1 = 3.3;
		d2 = 0;
	//	vdac = vref2;
	//	dummy = 0;
		dac[0] = 3.3*((value3 & (1 << 0))? 1:0);
		dac[1] = 3.3*((value3 & (1 << 1))? 1:0);
		dac[2] = 3.3*((value3 & (1 << 2))? 1:0);
		dac[3] = 3.3*((value3 & (1 << 3))? 1:0);
		dac[4] = 3.3*((value3 & (1 << 4))? 1:0);
		dac[5] = 3.3*((value3 & (1 << 5))? 1:0);

		//en_cs = 0;
		en_cs = 3.3;
	end

	@(timer(time_aux2 + start_delay+phase_duration+pause_duration+phase_duration)) begin
		u1 = 0;
		u2 = 0;
		d1 = 0;
		d2 = 0;
	//	vdac = 0;
	//	dummy = 3.3;
		dac[0] = 0;
		dac[1] = 0;
		dac[2] = 0;
		dac[3] = 0;
		dac[4] = 0;
		dac[5] = 0;

		//en_cs = 3.3;
		en_cs = 0;
	end

	V(UP1)<+ transition(u1, td, tt);
	V(UP2)<+ transition(u2, td, tt);
	V(DOWN1)<+ transition(d1, td, tt);
	V(DOWN2)<+ transition(d2, td, tt);
	V(EN_CS_N)<+ transition(en_cs, td, tt);
//	V(DUMMY)<+ transition(dummy, td, tt);
	V(DAC[0])<+ transition(dac[0], td, tt);
	V(DAC[1])<+ transition(dac[1], td, tt);
	V(DAC[2])<+ transition(dac[2], td, tt);
	V(DAC[3])<+ transition(dac[3], td, tt);
	V(DAC[4])<+ transition(dac[4], td, tt);
	V(DAC[5])<+ transition(dac[5], td, tt);

end

endmodule
