ADE simulation setup
Run mode: Single Run, Sweeps and Corners
Tests:
  Short_Sim: ASKA_TOP/aska_top16_tb/config_analog_extracted, simulator ams
    Outputs: ((VT("/A") - VT("/ELE<0>")) / 100)
  POR_Sim (off): ASKA_TOP/aska_top16_tb/config_analog_extracted, simulator ams
    Outputs: ((VT("/A") - VT("/ELE<0>")) / 100)
  Long_Sim (off): ASKA_TOP/aska_top16_tb/config_verilog_an_fun_dig, simulator ams
    Outputs: ((VT("/A") - VT("/ELE<0>")) / 100)
Global variables:
  ADDR0 = 0
  ADDR1 = 0
  POR_PULSE = 0
  RES = 100
  VDD3 = 3.3
  VDD3_PULSE = 0
  VDDHV = 40
  VDDHV_PULSE = 0
Corners (all switched off):
  model folders: /pkg/xfab2/XKIT/xh018/cadence/v9_0/spectre/v9_0_2/lpmos, /pkg/xfab2/XKIT/xh018/cadence/v9_0/spectre/v9_0_2/occ/lpmos
  PROCESS_OCC (off): temperature=-40 85; config.scs[default], param.scs[3s], bip.scs[tm], cap.scs[wp ws], dio.scs[tm], mos.scs[wo wp ws wz], photo.scs[tm], res.scs[wp ws], tstep_occ.scs[1n], xh018.occ[multi_range_unlimited]
  PROCESS_OCC_TYP (off): config.scs[default], param.scs[3s], bip.scs[tm], cap.scs[tm], dio.scs[tm], mos.scs[tm], photo.scs[tm], res.scs[tm], tstep_occ.scs[1n], xh018.occ[multi_range_unlimited]
  PROCESS (off): config.scs[default], param.scs[3s], bip.scs[tm], cap.scs[wp ws], dio.scs[tm], mos.scs[wp ws wo wz], photo.scs[tm], res.scs[wp ws]
  PROCESS_BIP (off): config.scs[default], param.scs[3s], bip.scs[wp ws], cap.scs[wp ws], dio.scs[tm], mos.scs[wp ws wo wz], photo.scs[tm], res.scs[wp ws]
  PROCESS_BIP_TMP (off): temperature=-40 85; config.scs[default], param.scs[3s], bip.scs[wp ws], cap.scs[wp ws], dio.scs[tm], mos.scs[wp ws wo wz], photo.scs[tm], res.scs[wp ws]
  VDD_PR_BIP (off): VDD3=3.0 3.6; config.scs[default], param.scs[3s], bip.scs[wp ws], cap.scs[wp ws], dio.scs[tm], mos.scs[wp ws wo wz], photo.scs[tm], res.scs[wp ws]
  VDD_PR_BIP_TMP (off): temperature=-40 85; VDD3=3 3.6; config.scs[default], param.scs[3s], bip.scs[wp ws], cap.scs[wp ws], dio.scs[tm], mos.scs[wp ws wo wz], photo.scs[tm], res.scs[wp ws]
  VDD_PR_TMP (off): temperature=-40 85; VDD3=3 3.6; config.scs[default], param.scs[3s], bip.scs[tm], cap.scs[wp ws], dio.scs[tm], mos.scs[wp ws wo wz], photo.scs[tm], res.scs[wp ws]
  VDD_PR (off): config.scs[default], param.scs[3s], bip.scs[tm], cap.scs[wp ws], dio.scs[tm], mos.scs[wp ws wo wz], photo.scs[tm], res.scs[wp ws]
  PROCESS_TEMP: temperature=-40 85; config.scs[default], param.scs[3s], bip.scs[tm], cap.scs[wp ws], dio.scs[tm], mos.scs[wp ws wo wz], photo.scs[tm], res.scs[wp ws]
