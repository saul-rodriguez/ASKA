// VerilogA for CONSTANT_GM, constant_gm, veriloga

`include "constants.vams"
`include "disciplines.vams"

module constant_gm_i(GNDA, OUT1, OUT2, OUT3, VDD3);
inout GNDA;
electrical GNDA;
inout OUT1;
electrical OUT1;
inout OUT2;
electrical OUT2;
inout OUT3;
electrical OUT3;
inout VDD3;
electrical VDD3;

analog begin

I(OUT1) <+ -1e-6;
I(OUT2) <+ -1e-6;
I(OUT3) <+ -0.5e-6;

end

endmodule
