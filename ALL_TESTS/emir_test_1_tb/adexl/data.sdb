ADE simulation setup
Run mode: Single Run, Sweeps and Corners
Tests:
  ALL_TESTS:emir_test_1_tb:1: ALL_TESTS/emir_test_1_tb/config, simulator spectre
Global variables:
  VDC = 40
