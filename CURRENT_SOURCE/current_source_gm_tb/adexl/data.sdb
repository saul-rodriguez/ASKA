ADE simulation setup
Run mode: Single Run, Sweeps and Corners
Tests:
  CURRENT_SOURCE:current_source_gm_tb:1: CURRENT_SOURCE/current_source_gm_tb/config, simulator spectre
    Outputs: DC_GAIN; PSRR
  montecarlo (off): CURRENT_SOURCE/current_source_gm_tb/schematic, simulator spectre
    Outputs: DC_GAIN; PSRR; Hist_1mA; Hist_50mA
Global variables:
  VDD = 3.3
  VDD_AC = 0
  VDDH = 40
  VIN_AC = 1
  VIN_DC = 1
  VIN_STEP = 0.1
  VDD_STEP = 0
  VDDH_STEP = 0
Corners:
  model folders: /home/saul/pkg/xfab/XKIT/xh018/cadence/v9_0/spectre/v9_0_2/lpmos
  PROCESS (off): config.scs[default], param.scs[3s], bip.scs[tm], cap.scs[wp ws], dio.scs[tm], mos.scs[wp ws wo wz], photo.scs[tm], res.scs[wp ws]
  VDD_TEMP (off): temperature=-40 85; VDD=3.0  3.6; config.scs[default], param.scs[3s], bip.scs[tm], cap.scs[wp ws], dio.scs[tm], mos.scs[wp ws wo wz], photo.scs[tm], res.scs[wp ws]
