ADE simulation setup
Run mode: Single Run, Sweeps and Corners
Tests:
  CURRENT_SOURCE:current_source_gm_switch_tb:1: CURRENT_SOURCE/current_source_gm_switch_tb/schematic, simulator spectre
  CURRENT_SOURCE:current_source_gm_switch_tb:1:1 (off): CURRENT_SOURCE/current_source_gm_switch_tb/schematic, simulator spectre
Global variables:
  VDD = 3.3
  VDD_AC = 0
  VDDH = 40
Corners (all switched off):
  model folders: /home/saul/pkg/xfab/XKIT/xh018/cadence/v9_0/spectre/v9_0_2/lpmos
  C0 (off): config.scs[default], param.scs[3s], bip.scs[tm], cap.scs[wp ws], dio.scs[tm], mos.scs[wp ws wo wz], photo.scs[tm], res.scs[wp ws]
  VDD_TEMP: temperature=-40 85; VDD=3.0  3.6; config.scs[default], param.scs[3s], bip.scs[tm], cap.scs[wp ws], dio.scs[tm], mos.scs[wp ws wo wz], photo.scs[tm], res.scs[wp ws]
  VDD_TEMP_3V (off): temperature=-45; VDD=3.0; config.scs[default], param.scs[3s], bip.scs[tm], cap.scs[wp ws], dio.scs[tm], mos.scs[wp ws wo wz], photo.scs[tm], res.scs[wp ws]
