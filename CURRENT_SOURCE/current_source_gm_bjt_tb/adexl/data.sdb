ADE simulation setup
Run mode: Single Run, Sweeps and Corners
Tests:
  CURRENT_SOURCE:current_source_gm_bjt_tb:1: CURRENT_SOURCE/current_source_gm_bjt_tb/schematic, simulator spectre
Global variables:
  HV_STEP = 0
  VDDA = 3.3
  VDDHV = 45
  VIN_AC = 1
  VIN_DC = 0
