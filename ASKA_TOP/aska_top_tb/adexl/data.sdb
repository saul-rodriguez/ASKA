ADE simulation setup
Run mode: Single Run, Sweeps and Corners
Tests:
  ASKA_TOP:aska_top_tb:1: ASKA_TOP/aska_top_tb/config, simulator ams
Global variables:
  POR_PULSE = 0
  RES = 100
  VDD3 = 3.3
  VDD3_PULSE = 0
  VDDHV = 40
  VDDHV_PULSE = 0
  ADDR0 = 3.3
  ADDR1 = 3.3
