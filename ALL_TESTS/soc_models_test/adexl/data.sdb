ADE simulation setup
Run mode: Single Run, Sweeps and Corners
Tests:
  ALL_TESTS:soc_models_test:1 (off): ALL_TESTS/soc_models_test/schematic, simulator spectre
  SOA_test: ALL_TESTS/soc_models_test/schematic, simulator spectre
Global variables:
  VDS = 45
  VIN_STEP = 40
  VIN_DC = 4
