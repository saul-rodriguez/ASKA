ADE simulation setup
Run mode: Single Run, Sweeps and Corners
Tests:
  CHARACTERIZATION:FT:1: CHARACTERIZATION/FT/schematic, simulator spectre
Global variables:
  IDS1 = {From/To}Decade:1u:10:1m{From/To}
  L = 0.18u
  NF = 1
  VDS1 = 1
  WF = 10u
  IDS = 1m
  VDS = 1
