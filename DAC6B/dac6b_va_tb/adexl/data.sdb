ADE simulation setup
Run mode: Single Run, Sweeps and Corners
Tests:
  DAC6B:dac6b_tb:1: DAC6B/dac6b_va_tb/schematic, simulator spectre
    Outputs: CMRR
  DAC6B:dac6b_tb:1:1 (off): DAC6B/dac6b_va_tb/schematic, simulator spectre
    Outputs: CMRR; sample(VT("/VOUT") 8e-06 0.0006 "linear" 1e-05)
Global variables:
  VREF = 1.25
  VDD = 3.3
  INIT_CODE = 1
  VREF_PULSE = 0
  VDD_PULSE = 0
Corners:
  model folders: /home/saul/pkg/xfab/XKIT/xh018/cadence/v9_0/spectre/v9_0_2/lpmos
  PROCESS (off): config.scs[default], param.scs[3s], bip.scs[tm], cap.scs[wp ws], dio.scs[tm], mos.scs[wp ws wo wz], photo.scs[tm], res.scs[wp ws]
  VDD_TEMP (off): temperature=-40 85; VDD=3 3.6; config.scs[default], param.scs[3s], bip.scs[tm], cap.scs[wp ws], dio.scs[tm], mos.scs[wp ws wo wz], photo.scs[tm], res.scs[wp ws]
  PROCESS_TEMP (off): temperature=-40 85; config.scs[default], param.scs[3s], bip.scs[tm], cap.scs[wp ws], dio.scs[tm], mos.scs[wp ws wo wz], photo.scs[tm], res.scs[wp ws]
