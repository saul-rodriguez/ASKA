ADE simulation setup
Run mode: Single Run, Sweeps and Corners
Tests:
  ALL_TESTS:current_source_nedia:1: ALL_TESTS/current_source_nedia/schematic, simulator spectre
