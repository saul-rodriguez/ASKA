// VerilogA for DAC6B, dac6b_stimulus, veriloga

`include "constants.vams"
`include "disciplines.vams"

module dac6b_stimulus(D0,D1,D2,D3,D4,D5,EN_N);
inout D0,D1,D2,D3,D4,D5,EN_N;
electrical D0,D1,D2,D3,D4,D5,EN_N;

parameter real tt = 1e-09;
parameter real vh = 3.3;
parameter real vl = 0 ;
parameter period =10e-6;
parameter init_value = 0;
parameter init_enable = 1;

integer value, aux, enable;
real next;

analog begin

	@(initial_step) begin
		next = $abstime + period;
		value = init_value;
		enable = init_enable;
	end

	@(timer(next)) begin
		next = next + period;
		value = value + 1;

		if (value > 64) begin
			value = 0;
			if (enable == 0) begin
				enable = 1;
			end else begin
				enable = 0;
			end
		end
	end

	aux = (value & (1 << 0))? 1:0;
	V(D0) <+ transition(aux ? vh : vl, 0, tt);

	aux = (value & (1 << 1))? 1:0;
	V(D1) <+ transition(aux ? vh : vl, 0, tt);

	aux = (value & (1 << 2))? 1:0;
	V(D2) <+ transition(aux ? vh : vl, 0, tt);

	aux = (value & (1 << 3))? 1:0;
	V(D3) <+ transition(aux ? vh : vl, 0, tt);

	aux = (value & (1 << 4))? 1:0;
	V(D4) <+ transition(aux ? vh : vl, 0, tt);

	aux = (value & (1 << 5))? 1:0;
	V(D5) <+ transition(aux ? vh : vl, 0, tt);

	V(EN_N) <+ transition(enable ? vh : vl, 0, tt);

end

endmodule
