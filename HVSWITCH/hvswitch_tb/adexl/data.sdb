ADE simulation setup
Run mode: Monte Carlo Sampling
Tests:
  HVSWITCH:hvswitch_tb:1 (off): HVSWITCH/hvswitch_tb/config, simulator spectre
  SOA (off): HVSWITCH/hvswitch_tb/config, simulator spectre
    Outputs: VDC("/I0/GATEP")
  Montecarlo: HVSWITCH/hvswitch_tb/config, simulator spectre
    Outputs: VGS1_P; VDS1_P; VGS1_N; VDS1_N; VGS2_P1; VDS2_P1; VGS2_N1; VDS2_N1
Global variables:
  IDC = 50m
  VDDHV = 40
  DN1 = 0
  DN2 = 0
  UP1 = 0
  UP2 = 0
  CAP_EXT = 10p
  VDDHV_PULSE = 0
  VDD = 3.3
  VDAC = 330m
  VDAC2 = 1.65
  START_DELAY = 20u
  VDD_PULSE = 0
Corners:
  model folders: /home/saul/pkg/xfab/XKIT/xh018/cadence/v9_0/spectre/v9_0_2/lpmos, /home/saul/pkg/xfab/XKIT/xh018/cadence/v9_0/spectre/v9_0_2/occ/lpmos, /pkg/xfab/XKIT/xh018/cadence/v9_0/spectre/v9_0_2/occ/lpmos
  PROCESS_OCC (off): temperature=-40 85; config.scs[default], param.scs[3s], bip.scs[tm], cap.scs[wp ws], dio.scs[tm], mos.scs[wo wp ws wz], photo.scs[tm], res.scs[wp ws], tstep_occ.scs[1n], xh018.occ[multi_range_unlimited]
  TYP_OCC (off): config.scs[default], param.scs[3s], bip.scs[tm], cap.scs[tm], dio.scs[tm], mos.scs[tm], photo.scs[tm], res.scs[tm], tstep_occ.scs[1n], xh018.occ[multi_range_unlimited]
  PROCESS (off): config.scs[default], param.scs[3s], bip.scs[tm], cap.scs[wp ws], dio.scs[tm], mos.scs[wp ws wo wz], photo.scs[tm], res.scs[wp ws]
  VDD_PR_TMP (off): temperature=-40 85; VDD=3.0 3.6; config.scs[default], param.scs[3s], bip.scs[tm], cap.scs[wp ws], dio.scs[tm], mos.scs[wp ws wo wz], photo.scs[tm], res.scs[wp ws]
  VDD_PR (off): VDD=3.0 3.6; config.scs[default], param.scs[3s], bip.scs[tm], cap.scs[wp ws], dio.scs[tm], mos.scs[wp ws wo wz], photo.scs[tm], res.scs[wp ws]
  PROCESS_TEMP (off): temperature=-40 85; config.scs[default], param.scs[3s], bip.scs[tm], cap.scs[wp ws], dio.scs[tm], mos.scs[wp ws wo wz], photo.scs[tm], res.scs[wp ws]
Monte Carlo Sampling options: mcmethod=all, mcnumpoints=300, parasiticanalysis=0
