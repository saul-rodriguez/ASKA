ADE simulation setup
Run mode: Single Run, Sweeps and Corners
Tests:
  ALL_TESTS:mc_test:1: ALL_TESTS/mc_test/schematic, simulator spectre
  ALL_TESTS:mc_test:1:1 (off): ALL_TESTS/mc_test/schematic, simulator spectre
Corners:
  model folders: /home/saul/pkg/xfab/XKIT/xh018/cadence/v9_0/spectre/v9_0_2/lpmos
  C0: config.scs[default], param.scs[3s], bip.scs[tm], cap.scs[wp ws], dio.scs[tm], mos.scs[wp ws wo wz], photo.scs[tm], res.scs[wp ws]
  VDD_TEMP (off): temperature=-40 85; config.scs[default], param.scs[3s], bip.scs[tm], cap.scs[wp ws], dio.scs[tm], mos.scs[wp ws wo wz], photo.scs[tm], res.scs[wp ws]
