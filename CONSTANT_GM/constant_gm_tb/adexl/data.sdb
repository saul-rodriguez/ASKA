ADE simulation setup
Run mode: Monte Carlo Sampling
Tests:
  CONSTANT_GM:constant_gm_tb:1 (off): CONSTANT_GM/constant_gm_tb/config, simulator spectre
    Outputs: IDC("/I0/M7/D")
  Montecarlo: CONSTANT_GM/constant_gm_tb/config, simulator spectre
    Outputs: IDC("/I0/M7/D")
Global variables:
  VDD3 = 3.3
  VDD_PULSE = 0
Corners (all switched off):
  model folders: /home/saul/pkg/xfab/XKIT/xh018/cadence/v9_0/spectre/v9_0_2/lpmos, /home/saul/pkg/xfab/XKIT/xh018/cadence/v9_0/spectre/v9_0_2/occ/lpmos, /pkg/xfab/XKIT/xh018/cadence/v9_0/spectre/v9_0_2/occ/lpmos
  PROCESS_OCC (off): temperature=-40 85; config.scs[default], param.scs[3s], bip.scs[tm], cap.scs[wp ws], dio.scs[tm], mos.scs[wo wp ws wz], photo.scs[tm], res.scs[wp ws], tstep_occ.scs[1n], xh018.occ[multi_range_unlimited]
  PROCESS (off): config.scs[default], param.scs[3s], bip.scs[tm], cap.scs[wp ws], dio.scs[tm], mos.scs[wp ws wo wz], photo.scs[tm], res.scs[wp ws]
  PROCESS_BIP (off): config.scs[default], param.scs[3s], bip.scs[wp ws], cap.scs[wp ws], dio.scs[tm], mos.scs[wp ws wo wz], photo.scs[tm], res.scs[wp ws]
  PROCESS_BIP_TMP (off): temperature=-40 85; config.scs[default], param.scs[3s], bip.scs[wp ws], cap.scs[wp ws], dio.scs[tm], mos.scs[wp ws wo wz], photo.scs[tm], res.scs[wp ws]
  VDD_PR_BIP (off): VDD3=3.0 3.6; config.scs[default], param.scs[3s], bip.scs[wp ws], cap.scs[wp ws], dio.scs[tm], mos.scs[wp ws wo wz], photo.scs[tm], res.scs[wp ws]
  VDD_PR_BIP_TMP (off): temperature=-40 85; VDD3=3 3.6; config.scs[default], param.scs[3s], bip.scs[wp ws], cap.scs[wp ws], dio.scs[tm], mos.scs[wp ws wo wz], photo.scs[tm], res.scs[wp ws]
  VDD_PR_TMP (off): temperature=-40 85; VDD3=3 3.6; config.scs[default], param.scs[3s], bip.scs[tm], cap.scs[wp ws], dio.scs[tm], mos.scs[wp ws wo wz], photo.scs[tm], res.scs[wp ws]
  VDD_PR (off): config.scs[default], param.scs[3s], bip.scs[tm], cap.scs[wp ws], dio.scs[tm], mos.scs[wp ws wo wz], photo.scs[tm], res.scs[wp ws]
  PROCESS_TEMP: temperature=-40 85; config.scs[default], param.scs[3s], bip.scs[tm], cap.scs[wp ws], dio.scs[tm], mos.scs[wp ws wo wz], photo.scs[tm], res.scs[wp ws]
Monte Carlo Sampling options: mcmethod=all, mcnumpoints=300, parasiticanalysis=0
