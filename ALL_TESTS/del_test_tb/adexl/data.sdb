ADE simulation setup
Run mode: Single Run, Sweeps and Corners
Tests:
  ALL_TESTS:del_test_tb:1: ALL_TESTS/del_test_tb/config, simulator spectre
