ADE simulation setup
Run mode: Single Run, Sweeps and Corners
Tests:
  DAC6B:dac6b_tb:1: DAC6B/dac6b_tb/schematic, simulator spectre
Global variables:
  D0 = 3.3
  D1 = 3.3
  D2 = 0
  D3 = 0
  D4 = 0
  D5 = 0
  VREF = 1.25
Corners:
  model folders: /home/saul/pkg/xfab/XKIT/xh018/cadence/v9_0/spectre/v9_0_2/lpmos
  PROCESS (off): config.scs[default], param.scs[3s], bip.scs[tm], cap.scs[wp ws], dio.scs[tm], mos.scs[wp ws wo wz], photo.scs[tm], res.scs[wp ws]
  VDD_TEMP: temperature=-40 85; config.scs[default], param.scs[3s], bip.scs[tm], cap.scs[wp ws], dio.scs[tm], mos.scs[wp ws wo wz], photo.scs[tm], res.scs[wp ws]
