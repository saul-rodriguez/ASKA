ADE simulation setup
Run mode: Single Run, Sweeps and Corners
Tests:
  PULSE_GENERATOR:stimulus_tb:1: PULSE_GENERATOR/stimulus_tb/schematic, simulator spectre
