ADE simulation setup
Run mode: Monte Carlo Sampling
Tests:
  BANDGAP:bandgap_tb:1 (off): BANDGAP/bandgap_tb/config, simulator spectre
    Outputs: dB20(getData("/V0" ?result "xf"))
  Montecarlo: BANDGAP/bandgap_tb/config, simulator spectre
    Outputs: dB20(getData("/V0" ?result "xf"))
Global variables:
  VDD3 = 3.3
  VDD_PULSE = 100m
  IPULSE = 0
  IBIAS = 1u
  IBIAS_PULSE = 0
Corners (all switched off):
  model folders: /home/saul/pkg/xfab/XKIT/xh018/cadence/v9_0/spectre/v9_0_2/lpmos, /home/saul/pkg/xfab/XKIT/xh018/cadence/v9_0/spectre/v9_0_2/occ/lpmos, /pkg/xfab/XKIT/xh018/cadence/v9_0/spectre/v9_0_2/occ/lpmos
  PROCESS_OCC (off): temperature=-40 85; config.scs[default], param.scs[3s], bip.scs[tm], cap.scs[wp ws], dio.scs[tm], mos.scs[wo wp ws wz], photo.scs[tm], res.scs[wp ws], tstep_occ.scs[1n], xh018.occ[multi_range_unlimited]
  PROCESS (off): config.scs[default], param.scs[3s], bip.scs[tm], cap.scs[wp ws], dio.scs[tm], mos.scs[wp ws wo wz], photo.scs[tm], res.scs[wp ws]
  PROCESS_BIP (off): config.scs[default], param.scs[3s], bip.scs[wp ws], cap.scs[wp ws], dio.scs[tm], mos.scs[wp ws wo wz], photo.scs[tm], res.scs[wp ws]
  PROCESS_BIP_TMP (off): temperature=-40 85; config.scs[default], param.scs[3s], bip.scs[wp ws], cap.scs[wp ws], dio.scs[tm], mos.scs[wp ws wo wz], photo.scs[tm], res.scs[wp ws]
  VDD_PR_BIP (off): VDD3=3.0 3.6; config.scs[default], param.scs[3s], bip.scs[wp ws], cap.scs[wp ws], dio.scs[tm], mos.scs[wp ws wo wz], photo.scs[tm], res.scs[wp ws]
  VDD_PR_BIP_TMP (off): temperature=-40 85; VDD3=3 3.6; config.scs[default], param.scs[3s], bip.scs[wp ws], cap.scs[wp ws], dio.scs[tm], mos.scs[wp ws wo wz], photo.scs[tm], res.scs[wp ws]
  VDD_PR_TMP (off): temperature=-40 85; config.scs[default], param.scs[3s], bip.scs[tm], cap.scs[wp ws], dio.scs[tm], mos.scs[wp ws wo wz], photo.scs[tm], res.scs[wp ws]
  VDD_PR (off): config.scs[default], param.scs[3s], bip.scs[tm], cap.scs[wp ws], dio.scs[tm], mos.scs[wp ws wo wz], photo.scs[tm], res.scs[wp ws]
  PROCESS_TEMP (off): temperature=-40 85; config.scs[default], param.scs[3s], bip.scs[tm], cap.scs[wp ws], dio.scs[tm], mos.scs[wp ws wo wz], photo.scs[tm], res.scs[wp ws]
Monte Carlo Sampling options: mcmethod=all, mcnumpoints=300, parasiticanalysis=0
